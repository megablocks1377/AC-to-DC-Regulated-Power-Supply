* 12V AC RMS to 5V DC regulated power supply - standalone LTspice netlist
* Source is 11.9Vrms, 60Hz sine wave
* Model limitations: 7805_EDU is behavioral, not a vendor model.
.step param RL list 1k 470 220 100
V1 AC1 AC2 SINE(0 16.82914 60)
D1 AC1 VRAW D1N4007_EDU
D2 AC2 VRAW D1N4007_EDU
D3 0 AC1 D1N4007_EDU
D4 0 AC2 D1N4007_EDU
C_FILTER VRAW 0 1000u
R_BLEED VRAW 0 4.7k
C_IN VRAW 0 0.33u
XU1 VRAW 0 VOUT LM7805_EDU
C_OUT VOUT 0 0.1u
R_LOAD VOUT 0 {RL}
.model D1N4007_EDU D(Is=2.52n Rs=0.568 N=1.906 Cjo=35p M=0.333 Vj=0.75 Bv=1000 Ibv=5u Tt=2.23u)
.include LM7805_EDU.lib
.tran 0 250m 0 50u startup
.meas TRAN VRAW_AVG AVG V(VRAW) FROM=200m TO=250m
.meas TRAN VOUT_AVG AVG V(VOUT) FROM=200m TO=250m
.meas TRAN VRAW_MAX MAX V(VRAW) FROM=200m TO=250m
.meas TRAN VRAW_MIN MIN V(VRAW) FROM=200m TO=250m
.meas TRAN VRAW_RIPPLE PARAM VRAW_MAX-VRAW_MIN
.meas TRAN ILOAD_AVG AVG I(R_LOAD) FROM=200m TO=250m
.meas TRAN VOUT_MAX MAX V(VOUT) FROM=200m TO=250m
.meas TRAN VOUT_MIN MIN V(VOUT) FROM=200m TO=250m
.meas TRAN VOUT_RIPPLE PARAM VOUT_MAX-VOUT_MIN
.save V(AC1) V(AC2) V(VRAW) V(VOUT)
.end
